// ****************************************************************
// AMS simulation control file for xrun netlist based flow
// ****************************************************************
simulator lang=spectre

global 0

amsd {
    ie vsup=0.4
}

tran tran stop=1u annotate=status
