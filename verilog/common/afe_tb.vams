// Testbenches for the analog front end cells that every abstraction level has
// to provide, checked against the contract in `verilog/README.md` rather than
// against any one level's implementation of it. Compile one of
// `verilog/models/*` alongside this file and the same benches run against it,
// which is what keeps the levels interchangeable.
//
// Everything checked here is DC or functional, because that is all the contract
// promises: a driver's code range brackets its nominal impedance, a termination
// code does the same, a reference ladder is monotonic, a receiver hands back
// the bit that was driven at it, and each rail of the TX equalizer branch turns
// on and off with its enable. What each level does with an edge is its own
// business and is measured by `verilog/common/training_tb.sv`.

// Ideal comparator of two analog nets. Bench-only: no level models a cell like
// this, and nothing in the PHY instantiates one.
module comparator(a, b, out);
    input a, b;
    output out;
    electrical a, b, out;

    analog begin
        if (V(a) > V(b))
            V(out) <+ 1;
        else
            V(out) <+ 0;
    end
endmodule

module rdac_tb;

    // Parameters
    localparam integer SEL_MAX = (1 << `RDAC_SEL_BITS) - 1;

    // Electrical nets
    electrical vdd, vss, out0, out1, low, high;

    // Digital select buses
    reg [`RDAC_SEL_BITS-1:0] sel0;
    reg [`RDAC_SEL_BITS-1:0] sel1;

    wire cmp_out;

    integer result;

    // Instantiate RDACs
    rdac dut0 (
        .out(out0),
        .sel(sel0),
        .vdd(vdd),
        .vss(vss)
    );
    rdac dut1 (
        .out(out1),
        .sel(sel1),
        .vdd(vdd),
        .vss(vss)
    );

    // Compare RDAC outputs.
    comparator cmp (
        .a(out0),
        .b(out1),
        .out(cmp_out)
    );

    // Drive VDD/VSS as ideal sources
    analog begin
        V(vdd) <+ `VDD;
        V(vss) <+ 0.0;
    end

    initial begin
        sel0 = 0;
        sel1 = 1;

        // Sweep full ladder range
        repeat (SEL_MAX) begin
            #20;
            if (cmp_out !== 0) $display("Error: out0 should be less than out1");
            else $display("Correct comparison output for sel0 = %b, sel1 = %b", sel0, sel1);
            sel0 = sel0 + 1;
            sel1 = sel1 + 1;
        end

        sel0 = 1;
        sel1 = 0;

        // Sweep full ladder range
        repeat (SEL_MAX) begin
            #20;
            if (cmp_out !== 1) $display("Error: out1 should be less than out0");
            else $display("Correct comparison output for sel0 = %b, sel1 = %b", sel0, sel1);
            sel0 = sel0 + 1;
            sel1 = sel1 + 1;
        end

        #20;
        $finish;
    end

endmodule

module pad_driver_data_tb;
    localparam CYCLES = 16;    // number of test cycles
    reg din;
    reg [`PAD_DRIVER_SEGMENTS-1:0] pu_ctl, pd_ctlb;
    reg en, enb;
    electrical dout;
    electrical vdd, vss;
    real dout_sample;

    pad_driver_cell drv (
        .din(din),
        .pu_ctl(pu_ctl),
        .pd_ctlb(pd_ctlb),
        .en(en),
        .enb(enb),
        .dout(dout),
        .vdd(vdd),
        .vss(vss)
    );

    analog begin
        V(vdd) <+ `VDD;
        V(vss) <+ 0;
        dout_sample = V(dout);
    end

    initial begin
        // Every segment on: nothing is permanently enabled any more.
        pu_ctl = {`PAD_DRIVER_SEGMENTS{1'b1}};
        pd_ctlb = 0;
        en = 1;
        enb = 0;
    end

    integer i;
    reg actual;
    initial begin
        din = 0;
        #300;

        // Apply random inputs and check functionality
        for (i = 0; i < CYCLES; i=i+1) begin
            din = $random % 2;
            #300;
            actual = dout_sample > `VDD/2;
            $display("din = %b, dout = %b (analog %f V)", din, actual, dout_sample);
            if (actual !== din)
                $display("Error: dout does not match din");
        end

        $finish;
    end
endmodule

module pad_driver_impedance_tb;
    // TODO: Verify step size
    reg din;
    reg [`PAD_DRIVER_SEGMENTS-1:0] pu_ctl, pd_ctlb;
    reg en, enb;
    electrical dout;
    electrical vdd, vss;
    real dout_sample;

    pad_driver_cell drv (
        .din(din),
        .pu_ctl(pu_ctl),
        .pd_ctlb(pd_ctlb),
        .en(en),
        .enb(enb),
        .dout(dout),
        .vdd(vdd),
        .vss(vss)
    );

    analog begin
        V(vdd) <+ `VDD;
        V(vss) <+ 0;
        I(dout, vss) <+ V(dout, vss) / 50;
        I(vdd, dout) <+ V(vdd, dout) / 50;
        dout_sample = V(dout);
    end

    initial begin
        // One segment per rail: the weakest code short of turning off.
        pu_ctl = 1;
        pd_ctlb = ~40'b1;
        en = 1;
        enb = 0;
    end

    integer i;
    reg actual;
    real rtest;
    real r30;
    real vpu;
    real vpd;
    initial begin
        rtest = 50;
        r30 = 1/(1/`PAD_DRIVER_R_OUT + 1/rtest);
        vpu = rtest / (r30 + rtest) * `VDD;
        vpd = r30 / (r30 + rtest) * `VDD;
        din = 0;
        #300;

        // Check that lowest code is above 30 ohms
        $display("din = %b, pd_ctlb = %b, dout = %f", din, pd_ctlb, dout_sample);
        if (dout_sample < vpd) $display("Error: highest pull-down impedance is too low (vpd = %f)", vpd);
        pd_ctlb = 0;
        #300;
        $display("din = %b, pd_ctlb = %b, dout = %f", din, pd_ctlb, dout_sample);
        if (dout_sample > vpd) $display("Error: lowest pull-down impedance is too high (vpd = %f)", vpd);
        din = 1;
        #300;
        $display("din = %b, pu_ctl = %b, dout = %f", din, pu_ctl, dout_sample);
        if (dout_sample > vpu) $display("Error: highest pull-up impedance is too low (vpu = %f)", vpu);
        pu_ctl = {`PAD_DRIVER_SEGMENTS{1'b1}};
        #300;
        $display("din = %b, pu_ctl = %b, dout = %f", din, pu_ctl, dout_sample);
        if (dout_sample < vpu) $display("Error: lowest pull-up impedance is too high (vpu = %f)", vpu);

        $finish;
    end
endmodule

module tx_tile_driver_data_tb;
    localparam CYCLES = 16;    // number of test cycles
    reg din;
    reg [`TX_DRIVER_SEGMENTS-1:0] ENP, ENN;
    reg [`TX_DRIVER_EQ_SEGMENTS-1:0] ENP_EQ, ENN_EQ;
    electrical dout;
    electrical vddq, vss;
    real dout_sample;

    tx_tile_driver drv (
        .din(din),
        .ENP(ENP),
        .ENN(ENN),
        .ENP_EQ(ENP_EQ),
        .ENN_EQ(ENN_EQ),
        .dout(dout),
        .vddq(vddq),
        .vss(vss)
    );

    analog begin
        V(vddq) <+ `VDD;
        V(vss) <+ 0;
        dout_sample = V(dout);
    end

    // Every main segment on, equalizer branch off. Every enable is active high
    // but `ENP_EQ`, which is off at all ones.
    initial begin
        ENP = {`TX_DRIVER_SEGMENTS{1'b1}};
        ENN = {`TX_DRIVER_SEGMENTS{1'b1}};
        ENP_EQ = {`TX_DRIVER_EQ_SEGMENTS{1'b1}};
        ENN_EQ = 0;
    end

    integer i;
    reg actual;
    initial begin
        din = 0;
        #300;

        // Apply random inputs and check functionality
        for (i = 0; i < CYCLES; i=i+1) begin
            din = $random % 2;
            #300;
            actual = dout_sample > `VDD/2;
            $display("din = %b, dout = %b (analog %f V)", din, actual, dout_sample);
            if (actual !== din)
                $display("Error: dout does not match din");
        end

        $finish;
    end
endmodule

module tx_tile_driver_impedance_tb;
    reg din;
    reg [`TX_DRIVER_SEGMENTS-1:0] ENP, ENN;
    reg [`TX_DRIVER_EQ_SEGMENTS-1:0] ENP_EQ, ENN_EQ;
    electrical dout;
    electrical vddq, vss;
    real dout_sample;

    tx_tile_driver drv (
        .din(din),
        .ENP(ENP),
        .ENN(ENN),
        .ENP_EQ(ENP_EQ),
        .ENN_EQ(ENN_EQ),
        .dout(dout),
        .vddq(vddq),
        .vss(vss)
    );

    analog begin
        V(vddq) <+ `VDD;
        V(vss) <+ 0;
        I(dout, vss) <+ V(dout, vss) / 50;
        I(vddq, dout) <+ V(vddq, dout) / 50;
        dout_sample = V(dout);
    end

    // Starts off: every enable is active high but `ENP_EQ`, so the driver is
    // off with that one all ones and the rest all zeros. One segment per rail
    // with the equalizer branch off, set below, is then the weakest code it can
    // be set to short of that.
    initial begin
        ENP = 0;
        ENN = 0;
        ENP_EQ = {`TX_DRIVER_EQ_SEGMENTS{1'b1}};
        ENN_EQ = 0;
    end

    real rtest;
    real r30;
    real vpu;
    real vpd;
    initial begin
        rtest = 50;
        r30 = 1/(1/`TX_R_OUT + 1/rtest);
        vpu = rtest / (r30 + rtest) * `VDD;
        vpd = r30 / (r30 + rtest) * `VDD;

        // Off, the driver should leave the bump to the load whatever `din` is:
        // the two test resistors put it at mid-rail.
        din = 0;
        #300;
        $display("din = %b, all enables off, dout = %f", din, dout_sample);
        if (dout_sample < 0.49 * `VDD || dout_sample > 0.51 * `VDD)
            $display("Error: driver with every enable off is not high impedance");
        din = 1;
        #300;
        $display("din = %b, all enables off, dout = %f", din, dout_sample);
        if (dout_sample < 0.49 * `VDD || dout_sample > 0.51 * `VDD)
            $display("Error: driver with every enable off is not high impedance");

        ENP = 1;
        ENN = 1;
        din = 0;
        #300;

        // The weakest pull-down code should sit above 30 ohms, the strongest
        // below it; likewise for the pull-up.
        $display("din = %b, ENN = %b, dout = %f", din, ENN, dout_sample);
        if (dout_sample < vpd) $display("Error: highest pull-down impedance is too low (vpd = %f)", vpd);
        ENN = {`TX_DRIVER_SEGMENTS{1'b1}};
        #300;
        $display("din = %b, ENN = %b, dout = %f", din, ENN, dout_sample);
        if (dout_sample > vpd) $display("Error: lowest pull-down impedance is too high (vpd = %f)", vpd);
        din = 1;
        #300;
        $display("din = %b, ENP = %b, dout = %f", din, ENP, dout_sample);
        if (dout_sample > vpu) $display("Error: highest pull-up impedance is too low (vpu = %f)", vpu);
        ENP = {`TX_DRIVER_SEGMENTS{1'b1}};
        #300;
        $display("din = %b, ENP = %b, dout = %f", din, ENP, dout_sample);
        if (dout_sample < vpu) $display("Error: lowest pull-up impedance is too high (vpu = %f)", vpu);

        $finish;
    end
endmodule

// The equalizer branch, one rail at a time. The levels disagree about what the
// branch does to an edge -- a DC conductance at the eye level, a kick through
// its series capacitor at the circuit level -- so this checks only what both
// owe: with the branch off the bump does not move whatever `din` does, and each
// rail's half, on by itself, pulls the bump toward its rail as `din` moves that
// way. That pins the polarity of both enables: `ENN_EQ` is active high and
// `ENP_EQ` active low, so the branch is off with `ENP_EQ` all ones and
// `ENN_EQ` all zeros.
//
// The main stack stays off throughout, so nothing else drives the bump, and the
// load holds it at mid-rail.
module tx_tile_driver_eq_tb;
    // How long after an edge to watch the bump (ps): the connect module's edge
    // and the circuit level's kick decaying into the load both fit well inside.
    localparam WINDOW = 150;
    // Least excursion from mid-rail (V) that counts as the bump being pulled,
    // and most that still counts as it staying put.
    localparam real PULLED = 0.02;
    localparam real QUIET = 0.005;

    reg din;
    reg [`TX_DRIVER_SEGMENTS-1:0] ENP, ENN;
    reg [`TX_DRIVER_EQ_SEGMENTS-1:0] ENP_EQ, ENN_EQ;
    electrical dout;
    electrical vddq, vss;
    real dout_sample;

    tx_tile_driver drv (
        .din(din),
        .ENP(ENP),
        .ENN(ENN),
        .ENP_EQ(ENP_EQ),
        .ENN_EQ(ENN_EQ),
        .dout(dout),
        .vddq(vddq),
        .vss(vss)
    );

    analog begin
        V(vddq) <+ `VDD;
        V(vss) <+ 0;
        I(dout, vss) <+ V(dout, vss) / 50;
        I(vddq, dout) <+ V(vddq, dout) / 50;
        dout_sample = V(dout);
    end

    initial begin
        din = 0;
        ENP = 0;
        ENN = 0;
        ENP_EQ = {`TX_DRIVER_EQ_SEGMENTS{1'b1}};
        ENN_EQ = 0;
    end

    // Highest and lowest the bump gets, relative to mid-rail, over `WINDOW`
    // after `din` is driven to `value`.
    real hi, lo;
    task drive(input value);
        integer t;
        begin
            din = value;
            hi = 0;
            lo = 0;
            for (t = 0; t < WINDOW; t = t + 1) begin
                #1;
                if (dout_sample - `VDD/2 > hi) hi = dout_sample - `VDD/2;
                if (dout_sample - `VDD/2 < lo) lo = dout_sample - `VDD/2;
            end
            $display("din -> %b, ENP_EQ = %b, ENN_EQ = %b: dout within [%f, %f] V of mid-rail",
                value, ENP_EQ, ENN_EQ, lo, hi);
        end
    endtask

    initial begin
        #300;

        // Off: no edge moves the bump.
        drive(1);
        if (hi > QUIET || lo < -QUIET)
            $display("Error: equalizer branch off moves the bump on a rising edge");
        drive(0);
        if (hi > QUIET || lo < -QUIET)
            $display("Error: equalizer branch off moves the bump on a falling edge");

        // Pull-up half alone: `ENP_EQ` low, `ENN_EQ` still low. A rising edge
        // pulls the bump up, and nothing pulls it down.
        ENP_EQ = 0;
        #300;
        drive(1);
        if (hi < PULLED)
            $display("Error: equalizer with ENP_EQ low does not pull the bump up");
        if (lo < -QUIET)
            $display("Error: equalizer pull-up half pulls the bump down");

        // Pull-down half alone: `ENN_EQ` high, `ENP_EQ` back high. Switched over
        // while `din` is high, so neither half is selected until it falls.
        ENP_EQ = {`TX_DRIVER_EQ_SEGMENTS{1'b1}};
        ENN_EQ = {`TX_DRIVER_EQ_SEGMENTS{1'b1}};
        #300;
        drive(0);
        if (lo > -PULLED)
            $display("Error: equalizer with ENN_EQ high does not pull the bump down");
        if (hi > QUIET)
            $display("Error: equalizer pull-down half pulls the bump up");

        $finish;
    end
endmodule

module rx_afe_tb;
    parameter CYCLES = 16;    // number of test cycles

    reg a_en, a_pc, b_en, b_pc, sel_a, din_dig;
    electrical vref, din, vdd, vss;
    wire dout;
    rx_afe afe(
        .vref(vref),
        .din(din),
        .a_en(a_en),
        .a_pc(a_pc),
        .b_en(b_en),
        .b_pc(b_pc),
        .sel_a(sel_a),
        .dout(dout),
        .vdd(vdd),
        .vss(vss)
    );

    analog begin
        V(vdd) <+ `VDD;
        V(vss) <+ 0;
        V(vref) <+ `RX_V_HIGH / 2;
        V(din) <+ transition(din_dig, 0, `T_RISE_FALL_DEFAULT * 1p) * `RX_V_HIGH;
    end

    initial begin
        a_pc = 1;
        b_pc = 1;
        a_en = 0;
        b_en = 0;
        sel_a = 1;
    end

    initial begin
        #1000;
        forever begin
            a_pc = 0;
            #100;
            a_en = 1;
            #100;
            sel_a = 1;
            #100;
            b_en = 0;
            #100;
            b_pc = 1;
            #1000;
            b_pc = 0;
            #100;
            b_en = 1;
            #100;
            sel_a = 0;
            #100;
            a_en = 0;
            #100;
            a_pc = 1;
            #1000;
        end
    end

    integer i;
    initial begin
        din_dig = 0;
        $display("waiting for a_pc");
        @(negedge a_pc);
        #300;

        // Apply random inputs
        for (i = 0; i < CYCLES; i=i+1) begin
            din_dig = $random % 2;
            #300;
            $display("din = %b, dout %b", din_dig, dout);
            if (dout !== din_dig)
                $display("Error: dout does not match din");
        end

        $finish;
    end

endmodule

module termination_tb;
    // TODO: Verify step size
    reg [`TERMINATION_CTL_BITS-1:0] zctl;
    reg en;
    electrical vin, vdd, vss;
    real vin_sample;

    termination term (
        .vin(vin),
        .zctl(zctl),
        .en(en),
        .vss(vss)
    );

    analog begin
        V(vdd) <+ `VDD;
        V(vss) <+ 0;
        I(vdd, vin) <+ V(vdd, vin) / `RX_R_IN;
        vin_sample = V(vin);
    end

    initial begin
        zctl = 0;
        en = 1;
    end

    integer i;
    reg actual;
    real vmid;
    initial begin
        vmid = `VDD/2;
        #300;

        // Check that lowest code is above 30 ohms
        $display("vin = %f, zctl = %b", vin_sample, zctl);
        if (vin_sample < vmid) $display("Error: highest termination impedance is too low (vmid = %f)", vmid);
        zctl = {`TERMINATION_CTL_BITS{1'b1}};
        #300;
        $display("vin = %f, zctl = %b", vin_sample, zctl);
        if (vin_sample > vmid) $display("Error: lowest termination impedance is too high (vmid = %f)", vmid);

        $finish;
    end
endmodule
