module rdac(out, sel, vdd, vss);
    parameter integer SEL_BITS = 8;
    output out;
    input [SEL_BITS:0] sel;
    inout vdd, vss;

    electrical out, vdd, vss;

    analog begin
        V(out) <+ (V(vdd) - V(vss)) * sel / (2 ** SEL_BITS) + V(vss);
    end
endmodule

module comparator(a, b, out);
    input a, b;
    output out;
    electrical a, b, out;

    analog begin
        if (V(a) > V(b))
            V(out) <+ 1;
        else
            V(out) <+ 0;
    end
endmodule

module tb_rdac;

    // Parameters
    parameter integer SEL_BITS = 8;
    localparam integer SEL_MAX = (1 << SEL_BITS) - 1;

    // Electrical nets
    electrical vdd, vss, out0, out1, low, high, cmp_out;

    // Digital select buses
    reg [SEL_BITS:0] sel0;
    reg [SEL_BITS:0] sel1;

    integer result;

    // Instantiate RDACs
    rdac #(
        .SEL_BITS(SEL_BITS)
    ) dut0 (
        .out(out0),
        .sel(sel0),
        .vdd(vdd),
        .vss(vss)
    );
    rdac #(
        .SEL_BITS(SEL_BITS)
    ) dut1 (
        .out(out1),
        .sel(sel1),
        .vdd(vdd),
        .vss(vss)
    );

    // Compare RDAC outputs.
    comparator cmp (
        .a(out0),
        .b(out1),
        .out(cmp_out)
    );

    // Drive VDD/VSS as ideal sources
    analog begin
        V(vdd) <+ 0.4;   // 0.4 V supply
        V(vss) <+ 0.0;   // ground
        result = V(cmp_out);
    end

    initial begin
        sel0 = 0;
        sel1 = 1;

        // Sweep full ladder range
        repeat (SEL_MAX) begin
            #20;
            if (result != 0) $display("Error: out0 should be less than out1");
            else $display("Correct comparison output for sel0 = %b, sel1 = %b", sel0, sel1);
            sel0 = sel0 + 1;
            sel1 = sel1 + 1;
        end

        sel0 = 1;
        sel1 = 0;

        // Sweep full ladder range
        repeat (SEL_MAX) begin
            #20;
            if (result != 1) $display("Error: out1 should be less than out0");
            else $display("Correct comparison output for sel0 = %b, sel1 = %b", sel0, sel1);
            sel0 = sel0 + 1;
            sel1 = sel1 + 1;
        end

        #20;
        $finish;
    end

endmodule
