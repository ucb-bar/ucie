// Circuit-level analog primitives: the reference ladder, and the inverter,
// capacitor and switch that `models/circuit/rx.vams` builds its sampler out of.
//
// `inv`, `cap` and `sw` exist only because that sampler is modelled as a
// circuit. `models/eye` has no counterpart for them, because nothing at that
// level is built out of anything.

module rdac(out, sel, vdd, vss);
    output out;
    input [`RDAC_SEL_BITS-1:0] sel;
    inout vdd, vss;

    electrical out, vdd, vss;

    analog begin
        V(out, vss) <+ V(vdd, vss) * transition(sel, 0, `T_RISE_FALL_DEFAULT * 1p) / (2 ** `RDAC_SEL_BITS);
    end
endmodule

module inv(a, o, vdd, vss);
    input a;
    output o;
    inout vdd, vss;
    electrical a, o, vdd, vss;
    parameter real VTH = `INV_VTH_DEFAULT;
    parameter real GAIN = `INV_GAIN_DEFAULT;

    analog begin
        V(o, vss) <+ tanh(-(V(a, vss) - VTH) * GAIN) * V(vdd, vss)/2 + V(vdd, vss)/2;
    end
endmodule

module inv_selfbias_tb;
    electrical o, vdd, vss;
    inv dut(.a(o), .o(o), .vdd(vdd), .vss(vss));
    real out;
    analog begin
        V(vdd) <+ `VDD;
        V(vss) <+ 0;
        out = V(o);
    end

    initial begin
        #10
        $display("Vout = %f", out);
        if (abs(out - `INV_VTH_DEFAULT) > 0.01) begin
            $display("Error: incorrect Vout");
        end
        $finish;
    end
endmodule

module cap(p, n);
    inout p, n;
    electrical p, n;
    parameter real C=1e-12 from [0:inf);
    parameter real R_LEAK=1000 from [0:inf);

    analog begin
        I(p,n) <+ C*ddt(V(p,n));
        I(p,n) <+ V(p,n) / R_LEAK;
    end
endmodule

module sw(p, n, s);
    parameter real R_ON=1 from [0:inf);
    parameter real R_OFF=1e6 from [0:inf);
    input s;
    output p, n;
    logic s;
    electrical p, n;

    analog begin
        I(p, n) <+ V(p, n) / (R_ON  + (R_OFF - R_ON) * (1 - transition(s, 0, `T_RISE_FALL_DEFAULT * 1p)));
    end
endmodule

module inv_discharge_cap_tb;
    electrical a, o, vdd, vss;
    reg pc;

    inv dut(.a(a), .o(o), .vdd(vdd), .vss(vss));
    sw s(.p(a), .n(o), .s(pc));
    cap c(.p(vdd), .n(a));
    real out;
    analog begin
        V(vdd) <+ `VDD;
        V(vss) <+ 0;
        out = V(vdd, a);
    end

    initial begin
        pc = 1;
        $display("Vout = %f", out);
        #10
        pc = 0;
        $display("Vout = %f", out);
        if (abs(out - `INV_VTH_DEFAULT) > 0.01) begin
            $display("Error: incorrect Vout");
        end
        #100000
        $display("Vout = %f", out);
        if (abs(out) > 0.01) begin
            $display("Error: incorrect Vout");
        end
        $finish;
    end
endmodule
