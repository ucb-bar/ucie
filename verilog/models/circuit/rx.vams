// Circuit-level models of the RX analog front end: the bump termination and
// the sampler that turns the level on the bump into a bit.
//
// `rx_afe` is the auto-zeroing sampler as it is actually built. Two
// switched-capacitor halves take turns: while one is precharging, its input
// switch ties the capacitor's top plate to `vref` and its zeroing switch
// diode-connects the inverter behind it, which parks the bottom plate at that
// inverter's own threshold and leaves `vref - Vth` across the capacitor. When
// the half is enabled instead, the top plate is driven by the pad and the
// bottom plate lands at `Vth + (din - vref)`, so the inverter slices the
// difference about the threshold it was just biased to -- which is what cancels
// its offset. `sel_a` hands the lane to whichever half is evaluating.
//
// The comparison is therefore an emergent property of the switches and
// capacitors here, not something the model states; `models/eye` states it
// directly instead. See `verilog/README.md`.

module rx_afe(
    inout vref,
    input din,
    input a_en,
    input a_pc,
    input b_en,
    input b_pc,
    input sel_a,
    output dout,
    inout vdd,
    inout vss
);
    electrical vref, din, dout, vdd, vss, a_cap_p, a_cap_n, b_cap_p, b_cap_n, mux_a_b, mux_a, mux_b_b, mux_b;

    sw a_sw_pc(.p(vref), .n(a_cap_p), .s(a_pc));
    sw b_sw_pc(.p(vref), .n(b_cap_p), .s(b_pc));
    sw a_sw_zero(.p(a_cap_n), .n(mux_a_b), .s(a_pc));
    sw b_sw_zero(.p(b_cap_n), .n(mux_b_b), .s(b_pc));
    sw a_sw_en(.p(din), .n(a_cap_p), .s(a_en));
    sw b_sw_en(.p(din), .n(b_cap_p), .s(b_en));

    cap ca(.p(a_cap_p), .n(a_cap_n));
    cap cb(.p(b_cap_p), .n(b_cap_n));

    inv a_inv_pc(.a(a_cap_n), .o(mux_a_b), .vdd(vdd), .vss(vss));
    inv b_inv_pc(.a(b_cap_n), .o(mux_b_b), .vdd(vdd), .vss(vss));
    inv a_inv_d(.a(mux_a_b), .o(mux_a), .vdd(vdd), .vss(vss));
    inv b_inv_d(.a(mux_b_b), .o(mux_b), .vdd(vdd), .vss(vss));

    mux m(.a(mux_a), .b(mux_b), .sel_a(sel_a), .o(dout));
endmodule

module termination(
    input vin,
    input en,
    input [`TERMINATION_CTL_BITS-1:0] zctl,
    inout vss
);
    electrical vin, vss;

    integer i;
    integer num_on;
    analog begin
        I(vin, vss) <+ V(vin, vss) / (
            (
                transition(1 - en, 0, `T_RISE_FALL_DEFAULT * 1p)
                * (`TERMINATION_R_OFF_SEGMENT - `TERMINATION_R_SEGMENT)
                + `TERMINATION_R_SEGMENT
            )
        ) * (`TERMINATION_SEGMENTS - `TERMINATION_CTL_BITS);
        num_on = 0;
        for (i = 0; i < `TERMINATION_CTL_BITS; i=i+1) begin
            if (zctl[i])
                num_on = num_on + 1;
        end
        I(vin, vss) <+ V(vin, vss) / `TERMINATION_R_SEGMENT * transition(num_on, 0, `T_RISE_FALL_DEFAULT * 1p);
        I(vin, vss) <+ V(vin, vss) / `TERMINATION_R_OFF_SEGMENT * transition(`TERMINATION_CTL_BITS - num_on, 0, `T_RISE_FALL_DEFAULT * 1p);
    end

endmodule
