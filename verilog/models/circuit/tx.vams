// Circuit-level models of the TX analog front end: the pad driver behind a
// sideband or debug bump, and the output driver of a mainband TX tile.
//
// Both resolve the driver down to its segments. Each thermometer bit switches
// one unit stack in or out, so an impedance code is a count of stacks in
// parallel and every code the pins accept is reachable, including ones no
// binary code could express. The edge is not a model parameter here: `din` is
// an electrical net, so its slew is whatever the digital-to-analog connect
// modules in `xcelium/amscf.scs` produce, which is where a real pre-driver
// model would go.
//
// See `verilog/README.md` for what separates this from `models/eye`.

// Analog model of a pad output driver segment stack, nominally
// `PAD_DRIVER_R_OUT` at `PAD_DRIVER_NOMINAL_SEGMENTS` of its
// `PAD_DRIVER_SEGMENTS` segments enabled.
module pad_driver_cell (
    input din,
    input [`PAD_DRIVER_SEGMENTS-1:0] pu_ctl, pd_ctlb,
    input en, enb,
    output dout,
    inout vdd, vss
);
    electrical din, dout, vdd, vss;

    integer i, pu_on, pd_on;
    analog begin
        // `pu_ctl` is thermometer coded and active high, `pd_ctlb` thermometer
        // coded and active low, so both read as a count of enabled segments.
        // Every segment is code controlled, so an all-off code leaves the
        // driver off.
        pu_on = 0;
        for (i = 0; i < `PAD_DRIVER_SEGMENTS; i=i+1) begin
            if (pu_ctl[i])
                pu_on = pu_on + 1;
        end
        pd_on = 0;
        for (i = 0; i < `PAD_DRIVER_SEGMENTS; i=i+1) begin
            if (!pd_ctlb[i])
                pd_on = pd_on + 1;
        end

        // A segment only conducts while the pre-driver selects its rail and
        // the driver is enabled.
        I(vdd, dout) <+ V(vdd, dout) * V(din, vss)/`VDD
            * transition(en, 0, `T_RISE_FALL_DEFAULT * 1p)
            * transition(pu_on, 0, `T_RISE_FALL_DEFAULT * 1p)
            / `PAD_DRIVER_R_SEGMENT;
        I(dout, vss) <+ V(dout, vss) * (1 - V(din, vss)/`VDD)
            * transition(!enb, 0, `T_RISE_FALL_DEFAULT * 1p)
            * transition(pd_on, 0, `T_RISE_FALL_DEFAULT * 1p)
            / `PAD_DRIVER_R_SEGMENT;

        // Leakage through the segments that are off or not selected.
        I(vdd, dout) <+ V(vdd, dout) / `DRIVER_R_OFF_SEGMENT;
        I(dout, vss) <+ V(dout, vss) / `DRIVER_R_OFF_SEGMENT;
    end
endmodule

// Output driver of a UCIe TX tile: an N-over-N stack whose pull-up and
// pull-down impedance is set by the thermometer codes `ENP` and `ENN`, next to
// a capacitive-peaking equalizer branch set by `ENP_EQ` and `ENN_EQ`.
//
// `ENP`, `ENN` and `ENN_EQ` are active high. `ENP_EQ` is active low, because
// it gates the equalizer's PMOS headers directly: a zero turns its segment on.
// So the output is high impedance with `ENP`, `ENN` and `ENN_EQ` all zeros and
// `ENP_EQ` all ones.
//
// The equalizer branch is an inverter of switched segments, in phase with the
// main stack, that reaches the bump only through `TX_DRIVER_EQ_C`. It adds
// nothing at DC: what it adds is a kick on each edge, decaying through that
// capacitor into whatever loads the bump. In the tile it runs off VDD rather
// than VDDQ; `vddq` stands in for both, as every bench ties them together.
module tx_tile_driver (
    input din,
    input [`TX_DRIVER_SEGMENTS-1:0] ENP, ENN,
    input [`TX_DRIVER_EQ_SEGMENTS-1:0] ENP_EQ, ENN_EQ,
    output dout,
    inout vddq, vss
);
    electrical din, dout, vddq, vss;
    // Output of the equalizer's inverter, the far plate of `TX_DRIVER_EQ_C`.
    electrical eq;

    integer i, pu_on, pd_on, pu_eq_on, pd_eq_on;
    analog begin
        // Count the enabled segments on each rail.
        pu_on = 0;
        for (i = 0; i < `TX_DRIVER_SEGMENTS; i=i+1) begin
            if (ENP[i])
                pu_on = pu_on + 1;
        end
        pd_on = 0;
        for (i = 0; i < `TX_DRIVER_SEGMENTS; i=i+1) begin
            if (ENN[i])
                pd_on = pd_on + 1;
        end
        pu_eq_on = 0;
        for (i = 0; i < `TX_DRIVER_EQ_SEGMENTS; i=i+1) begin
            if (!ENP_EQ[i])
                pu_eq_on = pu_eq_on + 1;
        end
        pd_eq_on = 0;
        for (i = 0; i < `TX_DRIVER_EQ_SEGMENTS; i=i+1) begin
            if (ENN_EQ[i])
                pd_eq_on = pd_eq_on + 1;
        end

        // A segment only conducts while the pre-driver selects its rail, so
        // both stacks are scaled by `din`.
        I(vddq, dout) <+ V(vddq, dout) * V(din, vss)/`VDD
            * transition(pu_on, 0, `T_RISE_FALL_DEFAULT * 1p) / `TX_DRIVER_R_SEGMENT;
        I(dout, vss) <+ V(dout, vss) * (1 - V(din, vss)/`VDD)
            * transition(pd_on, 0, `T_RISE_FALL_DEFAULT * 1p) / `TX_DRIVER_R_SEGMENT;

        // The equalizer's segments switch on the same `din`, onto `eq`.
        I(vddq, eq) <+ V(vddq, eq) * V(din, vss)/`VDD
            * transition(pu_eq_on, 0, `T_RISE_FALL_DEFAULT * 1p) / `TX_DRIVER_EQ_R_SEGMENT;
        I(eq, vss) <+ V(eq, vss) * (1 - V(din, vss)/`VDD)
            * transition(pd_eq_on, 0, `T_RISE_FALL_DEFAULT * 1p) / `TX_DRIVER_EQ_R_SEGMENT;
        I(eq, dout) <+ `TX_DRIVER_EQ_C * ddt(V(eq, dout));

        // Leakage through the segments that are off or not selected, which is
        // also what gives `eq` a DC level with the equalizer off.
        I(vddq, dout) <+ V(vddq, dout) / `DRIVER_R_OFF_SEGMENT;
        I(dout, vss) <+ V(dout, vss) / `DRIVER_R_OFF_SEGMENT;
        I(vddq, eq) <+ V(vddq, eq) / `DRIVER_R_OFF_SEGMENT;
        I(eq, vss) <+ V(eq, vss) / `DRIVER_R_OFF_SEGMENT;
    end
endmodule
