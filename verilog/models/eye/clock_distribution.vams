// Eye-level clock distribution network: one clock in, `LANES` copies out, each
// arriving at its own time.
//
// The static per-lane delay spread is kept, because lane-to-lane skew is
// exactly what per-lane deskew training exists to take out, and a network that
// handed every lane the same edge would make that training look free. Delays
// are drawn once per elaboration from N(`propagation_delay_mu`,
// `propagation_delay_sigma`).
//
// What `models/circuit` adds is the network's phase noise -- a white floor and
// a flicker component, common to every lane since they share a root -- sampled
// onto each edge as jitter. As in `models/eye/dcdl.vams`, jitter closes an eye
// rather than opening one, so it is left to the lower level.

`include "constants.vams"
`include "disciplines.vams"

module clocking_distribution_model(clk_in, clk_out);
    input clk_in; electrical clk_in;
    output [15:0] clk_out; electrical [15:0] clk_out;

    parameter real vdd = `VDD;
    parameter real propagation_delay_mu = 198p;
    parameter real propagation_delay_sigma = 541f;
    parameter real t_slew = `EYE_CLK_DIST_SLEW * 1p;

    real lane_delay[0:15];
    integer sign;
    integer seed;
    integer i;

    genvar j;

    analog begin
        @(initial_step) begin
            seed = $random + $abstime * 1e12;
            // `cross` fires on a crossing and not on where the operating point
            // started, so the initial solution sets the output level too.
            sign = (V(clk_in) > vdd / 2) ? 1 : 0;
            for (i = 0; i < 16; i = i + 1) begin
                lane_delay[i] = propagation_delay_mu
                    + propagation_delay_sigma * $rdist_normal(seed, 0, 1);
            end
        end

        @(cross(V(clk_in) - vdd/2, 1)) sign = 1;
        @(cross(V(clk_in) - vdd/2, -1)) sign = 0;

        for (j = 0; j < 16; j = j + 1) begin
            V(clk_out[j]) <+ transition(vdd * sign, lane_delay[j], t_slew);
        end
    end
endmodule

// Eye-level replica of one arm of the clock distribution network, for a signal
// that has to arrive with the same delay as a lane's clock but does not go
// through the tree: the received data in each RX data lane, which then lands at
// the deserializer as late as the clock that samples it.
//
// A replica is built from the same cells as an arm of the tree and so tracks
// it across process, voltage and temperature, but it is a different piece of
// silicon. Its delay is drawn once per elaboration from the same
// N(`propagation_delay_mu`, `propagation_delay_sigma`) as an arm's, and
// independently of every arm, so the arm and the replica of one lane differ by
// the spread of two draws rather than matching exactly.
module clock_tree_replica(din, dout);
    input din; electrical din;
    output dout; electrical dout;

    parameter real vdd = `VDD;
    parameter real propagation_delay_mu = 198p;
    parameter real propagation_delay_sigma = 541f;
    parameter real t_slew = `EYE_CLK_DIST_SLEW * 1p;

    real delay;
    integer sign;
    integer seed;

    analog begin
        @(initial_step) begin
            seed = $random + $abstime * 1e12;
            sign = (V(din) > vdd / 2) ? 1 : 0;
            delay = propagation_delay_mu
                + propagation_delay_sigma * $rdist_normal(seed, 0, 1);
        end

        @(cross(V(din) - vdd/2, 1)) sign = 1;
        @(cross(V(din) - vdd/2, -1)) sign = 0;

        V(dout) <+ transition(vdd * sign, delay, t_slew);
    end
endmodule
