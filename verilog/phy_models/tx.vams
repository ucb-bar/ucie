module tree_serializer #(
    parameter integer K = 3,              // log2(#inputs)
    parameter integer M = (1 << K)        // number of inputs
)(
    input  logic          clk,            // serialization clock
    input  logic          rst,            // synchronous reset
    input  logic [M-1:0]  din,            // parallel inputs
    output reg          dout,           // serialized output
    output logic [$clog2(M)-1:0] idx      // current index
);

    // Internal select index
    logic [K-1:0] select_index;

    //
    // Index counter
    //
    always @(posedge clk or posedge rst) begin
        if (rst) begin
            select_index <= '0;
        end else begin
            select_index <= select_index + 1;
        end
    end

    assign idx = select_index;

    //
    // Tree-like selection
    // In a real tree serializer, muxing happens in a K-stage tree.
    // Behaviorally, selecting din[select_index] produces the same result.
    //
    always @(*) begin
        dout = din[select_index];
    end

endmodule
