// General
// Supply voltage (V)
`define VDD 0.75
// Min period (ps)
`define MIN_PERIOD 125
// Rise/fall time (ps)
`define T_RISE_FALL_DEFAULT 5
// Number of lanes
`define LANES 16
// Pi
`define M_PI 3.14159265358979323846

// PRIMITIVES
// Clock-to-q and data-to-q delays of FFs and latches (ps)
`define T_CLKQ_DQ_DEFAULT 5.0
// Setup time of FFs and latches (ps)
`define T_SETUP_DEFAULT 5.0
// Hold time of FFs and latches (ps)
`define T_HOLD_DEFAULT 2.0
// Combinational delay of mux (ps)
`define MUX_DELAY_DEFAULT 5.0
// RDAC select bits
`define RDAC_SEL_BITS 8
// Inverter threshold voltage (V)
`define INV_VTH_DEFAULT (`VDD / 2)
// Inverter gain
`define INV_GAIN_DEFAULT 1000

// SERDES
// Number of stages for serializers/deserializers
`define SERDES_STAGES 5
// Number of stages for clock dividers
`define CLKDIV_STAGES (`SERDES_STAGES - 1)
// Deserializer input delay (ps)
`define DES_IN_DELAY 10.0

// DRIVER
// Off resistance of a driver segment (Ohms), shared by every driver model
`define DRIVER_R_OFF_SEGMENT 1000000

// PAD DRIVER
// Nominal pad driver output impedance (Ohms)
`define PAD_DRIVER_R_OUT 50.0
// Number of pad driver segments. Every one is code controlled, thermometer
// coded on `pu_ctl` and `pd_ctlb`, so the reachable range is 0 to
// `PAD_DRIVER_SEGMENTS` and an all-off code leaves the driver off.
`define PAD_DRIVER_SEGMENTS 40
// Segment count at which the driver hits `PAD_DRIVER_R_OUT`, picked near the
// middle of that range so calibration has codes on both sides of nominal.
`define PAD_DRIVER_NOMINAL_SEGMENTS 20
// Resistance of a single pad driver segment (Ohms)
`define PAD_DRIVER_R_SEGMENT (`PAD_DRIVER_NOMINAL_SEGMENTS * `PAD_DRIVER_R_OUT)

// CLOCK_PATH
// Clock period
`define CLK_PERIOD 125e-12
// Digitally-controlled delay line bit width
`define DCDL_CTRL_BITWIDTH 8
// Digitally-controlled delay line delay offset (ps)
`define DCDL_DELAY_OFS 10.0
// Digitally-controlled delay line delay sep (ps)
`define DCDL_DELAY_STEP 10.0
// Clock distribution mean delay
`define CLK_DIST_DELAY_MU 200e-12
// Clock distribution std deviation
`define CLK_DIST_DELAY_SIGMA 0.5e-12

// TX
// TX nominal output impedance (Ohms)
`define TX_R_OUT 30.0
// Number of segments in a TX tile's output driver (`ENP`/`ENN`)
`define TX_DRIVER_SEGMENTS 9
// Resistance of a single output driver segment (Ohms). Sized so that nominal
// `TX_R_OUT` lands one code short of the strongest setting, which leaves the
// impedance calibration codes on both sides of nominal.
`define TX_DRIVER_R_SEGMENT ((`TX_DRIVER_SEGMENTS - 1) * `TX_R_OUT)
// Number of segments in the capacitive-peaking equalizer branch
// (`ENP_EQ`/`ENN_EQ`)
`define TX_DRIVER_EQ_SEGMENTS 4
// The equalizer branch is assumed to be built from the same unit segment as
// the main driver, so at full code it reaches half of nominal drive.
`define TX_DRIVER_EQ_R_SEGMENT `TX_DRIVER_R_SEGMENT
// Number of taps in the delay line on a TX tile's high speed clock (`Dctrl`)
`define TX_DCDL_TAPS 32

// RX
// RX nominal input impedance (Ohms)
`define RX_R_IN 50.0
// RX voltage transfer function
`define RX_VTF (`RX_R_IN / (`RX_R_IN + `TX_R_OUT))
// High voltage for received data (V)
`define RX_V_HIGH (`VDD * `RX_VTF)
// Number of termination control bits
`define TERMINATION_CTL_BITS 5
// Number of termination segments
`define TERMINATION_SEGMENTS 32
// Resistance of single termination segment (Ohms)
`define TERMINATION_R_SEGMENT 1599
// Off resistance of termination (Ohms)
`define TERMINATION_R_OFF_SEGMENT 1000000

// EYE MODELS
// Knobs of the models in `verilog/models/eye`, the highest abstraction level.
// That level exists to put an eye in front of the receiver and a threshold in
// the middle of it, and these are the numbers that set both, so opening or
// closing the eye is a one line change here.
//
// How long a driver takes to hand its output from one rail to the other (ps).
// This is what closes the eye horizontally: a UI is `MIN_PERIOD`/2 = 62.5 ps at
// 16 GT/s, so the default leaves roughly two thirds of a UI open. The value
// matches the `tr`/`tf` of the digital-to-analog connect modules in
// `xcelium/amscf.scs`, which is where `models/circuit` gets its edges from, so
// the two levels present the receiver with the same edge rate.
`define EYE_TX_SLEW 20.0
// Propagation delay of the RX slicer, from the input crossing `vref` to its
// output starting to move (ps).
`define EYE_SLICER_DELAY 5.0
// Output transition time of the RX slicer (ps).
`define EYE_SLICER_SLEW 5.0
// Output transition time of the eye-level delay line (ps). Same as the `t_slew`
// the circuit-level cell defaults to, so the two levels put a lane's clock in
// the same place.
`define EYE_CLK_SLEW 20.0
// Output transition time of the eye-level clock distribution network (ps). The
// lane clocks land on logic nets, so this is what a connect module thresholds.
`define EYE_CLK_DIST_SLEW 5.0
