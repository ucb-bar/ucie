// Verilog-A model of a reference crystal oscillator with phase noise.
// Only a white phase noise floor is modeled here.

`include "constants.vams"
`include "disciplines.vams"

module model_ref_crystal(clk_ref);

output clk_ref; electrical clk_ref;

parameter integer steps_per_cycle = 100;
parameter real vdd = 0.75;
parameter real osc_freq = 100M; // nominal frequency in Hz
parameter real white_noise_floor_dBcHz = -160;

real white_noise_floor_linear;
real white_noise_td;
real white_noise_filtered;
real phase;

analog begin
    // Calculate white noise floor in linear scale
    white_noise_floor_linear = 10**(white_noise_floor_dBcHz/10);
    white_noise_td = white_noise(white_noise_floor_linear);
    // filter the white noise at Nyquist frequency to prevent folding
    white_noise_filtered = laplace_nd(white_noise_td, {1.0}, {1.0, 1.0/(`M_PI*osc_freq)});

    // Use linear phase accumulation instead of idtmod to avoid LTE convergence issues
    // This is valid since the reference crystal frequency is constant
    phase = 2 * `M_PI * osc_freq * $abstime + white_noise_filtered;

    $bound_step(1.0 / osc_freq / steps_per_cycle);
    V(clk_ref) <+ vdd/2 + vdd/2 * sin(phase);
end

endmodule
