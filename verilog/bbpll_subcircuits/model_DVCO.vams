// Verilog-A model of a digitally-voltage controlled oscillator with integrator-like phase noise.

`include "constants.vams"
`include "disciplines.vams"

`define DCTRL_BITWIDTH 8

module model_DVCO(Vctrl, Dctrl, clk_out, phase_noise_out);

input Vctrl; electrical Vctrl;
input Dctrl; electrical Dctrl;
output clk_out; electrical clk_out;
output phase_noise_out; electrical phase_noise_out;

parameter real clk_middle_freq = 8G;      // middle frequency of the VCO
parameter real Kvco = 32M;               // VCO gain in Hz/V
parameter real Kdco = 1.25M;                 // DCO gain in Hz/LSB
parameter real vdd = 0.75;
parameter real PN_WN_100MHz = -130;       // white noise floor at 100MHz offset in dBc/Hz
parameter real PN_FN_10kHz = -15;         // flicker noise at 10kHz offset in dBc/Hz
parameter integer steps_per_cycle = 100;
parameter real Dctrl_setpoint = 128;
parameter real Vctrl_setpoint = vdd/2;

real WN_PSD, FN_PSD;
real osc_modulated_freq;
real real_noise_integ;
real phase;
integer sign;

analog begin
    // Calculate instantaneous frequency from control inputs
    osc_modulated_freq = Kvco * (V(Vctrl) - Vctrl_setpoint) + Kdco * (V(Dctrl) - Dctrl_setpoint);

    // Calculate phase noise PSD
    WN_PSD = (2*`M_PI)**2 * (100M)**2 * (10**(PN_WN_100MHz/10));
    FN_PSD = (2*`M_PI)**2 * (10k)**3 * (10**(PN_FN_10kHz/10));
    real_noise_integ = white_noise(WN_PSD) + flicker_noise(FN_PSD, 1);

    // Accumulate phase with noise modulation
    phase = 2*`M_PI*clk_middle_freq*$abstime + idtmod(2*`M_PI*osc_modulated_freq, 0, 2*`M_PI) + idt(real_noise_integ);

    // Output phase noise for monitoring
    V(phase_noise_out) <+ real_noise_integ;

    // Bound simulation timestep
    $bound_step(1.0 / clk_middle_freq / steps_per_cycle);

    // Event-driven square wave output with smooth transitions
    @(cross(cos(phase), 0)) sign = cos(phase) > 0 ? 1 : 0;
    V(clk_out) <+ transition(sign * vdd, 5p, 5p);
end

endmodule
