// A simple delta-sigma modulator model in Verilog-A.
// Input is digital fractional value in [0, 1), output is a 1-bit digital stream.

`include "constants.vams"
`include "disciplines.vams"

module model_1storder_DSmodulator(Din_frac, clk, Dout);

input Din_frac; electrical Din_frac;  // Input fractional value in [0, 1)
input clk;      electrical clk;
output Dout;    electrical Dout;      // Output 1-bit digital stream

parameter real vdd = 0.75;
parameter real t_rise = 50p;

real accumulator;
integer Dout_value;

analog begin
    // Update accumulator on clock rising edge
    @(cross(V(clk) - vdd/2, 1)) begin
        accumulator = accumulator + V(Din_frac) - (V(Dout) > vdd/2 ? 1 : 0);

        if (accumulator >= 0.5) begin
            Dout_value = 1;
        end else begin
            Dout_value = 0;
        end
    end

    // Output with transition filtering
    V(Dout) <+ transition(Dout_value * vdd, 0, t_rise);
end

endmodule
