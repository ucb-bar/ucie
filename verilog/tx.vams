// Analog model of a pad output driver segment stack, nominally
// `PAD_DRIVER_R_OUT`. Only `PAD_DRIVER_CTL_BITS` segments are code controlled;
// the rest are always on whenever the driver is enabled.
module pad_driver_cell (
    input din,
    input [`PAD_DRIVER_CTL_BITS-1:0] pu_ctl, pd_ctlb,
    input en, enb,
    output dout,
    inout vdd, vss
);
    electrical din, dout, vdd, vss;

    integer i, pu_on, pd_on;
    analog begin
        // Enable pull-up segments
        I(vdd, dout) <+ V(vdd, dout) / (
            (
                (1 - V(din, vss)/`VDD*transition(en, 0, `T_RISE_FALL_DEFAULT * 1p))
                * (`DRIVER_R_OFF_SEGMENT - `PAD_DRIVER_R_SEGMENT)
                + `PAD_DRIVER_R_SEGMENT
            )
        ) *  (`PAD_DRIVER_SEGMENTS - `PAD_DRIVER_CTL_BITS);
        // Enable pull-down segments
        I(dout, vss) <+ V(dout, vss) / (
            (
                (1 - (1 - V(din, vss)/`VDD)*transition(!enb, 0, `T_RISE_FALL_DEFAULT * 1p))
                * (`DRIVER_R_OFF_SEGMENT - `PAD_DRIVER_R_SEGMENT)
                + `PAD_DRIVER_R_SEGMENT
            )
        ) * (`PAD_DRIVER_SEGMENTS - `PAD_DRIVER_CTL_BITS);

        // Control pull-up segments
        pu_on = 0;
        for (i = 0; i < `PAD_DRIVER_CTL_BITS; i=i+1) begin
            if (pu_ctl[i])
                pu_on = pu_on + 1;
        end
        I(vdd, dout) <+ V(vdd, dout) / `PAD_DRIVER_R_SEGMENT * V(din, vss)/`VDD * transition(pu_on, 0, `T_RISE_FALL_DEFAULT * 1p);
        I(vdd, dout) <+ V(vdd, dout) / `DRIVER_R_OFF_SEGMENT * (`PAD_DRIVER_CTL_BITS - V(din, vss)/`VDD * transition(pu_on, 0, `T_RISE_FALL_DEFAULT * 1p));

        // Control pull-down segments
        pd_on = 0;
        for (i = 0; i < `PAD_DRIVER_CTL_BITS; i=i+1) begin
            if (!pd_ctlb[i])
                pd_on = pd_on + 1;
        end
        I(dout, vss) <+ V(dout, vss) / `PAD_DRIVER_R_SEGMENT * (1 - V(din, vss)/`VDD) * transition(pd_on, 0, `T_RISE_FALL_DEFAULT * 1p);
        I(dout, vss) <+ V(dout, vss) / `DRIVER_R_OFF_SEGMENT * (`PAD_DRIVER_CTL_BITS - (1 - V(din, vss)/`VDD) * transition(`PAD_DRIVER_CTL_BITS - pd_on, 0, `T_RISE_FALL_DEFAULT * 1p));
    end
endmodule

// Output driver of a UCIe TX tile: an N-over-N stack whose pull-up and
// pull-down impedance is set by the thermometer codes `ENP` and `ENN`, next to
// a capacitive-peaking equalizer branch set by `ENP_EQ` and `ENN_EQ`.
//
// `ENP` and `ENP_EQ` are active low (a one turns its segment off); `ENN` and
// `ENN_EQ` are active high.
//
// TODO: the equalizer branch is modeled by its DC contribution alone. The
// series capacitor that gives the branch its high frequency boost is not
// modeled, so enabling it lowers the output impedance without sharpening any
// edges.
module tx_tile_driver (
    input din,
    input [`TX_DRIVER_SEGMENTS-1:0] ENP, ENN,
    input [`TX_DRIVER_EQ_SEGMENTS-1:0] ENP_EQ, ENN_EQ,
    output dout,
    inout vddq, vss
);
    electrical din, dout, vddq, vss;

    integer i, pu_on, pd_on, pu_eq_on, pd_eq_on;
    analog begin
        // Count the enabled segments on each rail.
        pu_on = 0;
        for (i = 0; i < `TX_DRIVER_SEGMENTS; i=i+1) begin
            if (!ENP[i])
                pu_on = pu_on + 1;
        end
        pd_on = 0;
        for (i = 0; i < `TX_DRIVER_SEGMENTS; i=i+1) begin
            if (ENN[i])
                pd_on = pd_on + 1;
        end
        pu_eq_on = 0;
        for (i = 0; i < `TX_DRIVER_EQ_SEGMENTS; i=i+1) begin
            if (!ENP_EQ[i])
                pu_eq_on = pu_eq_on + 1;
        end
        pd_eq_on = 0;
        for (i = 0; i < `TX_DRIVER_EQ_SEGMENTS; i=i+1) begin
            if (ENN_EQ[i])
                pd_eq_on = pd_eq_on + 1;
        end

        // A segment only conducts while the pre-driver selects its rail, so
        // both stacks are scaled by `din`.
        I(vddq, dout) <+ V(vddq, dout) * V(din, vss)/`VDD * (
            transition(pu_on, 0, `T_RISE_FALL_DEFAULT * 1p) / `TX_DRIVER_R_SEGMENT
            + transition(pu_eq_on, 0, `T_RISE_FALL_DEFAULT * 1p) / `TX_DRIVER_EQ_R_SEGMENT
        );
        I(dout, vss) <+ V(dout, vss) * (1 - V(din, vss)/`VDD) * (
            transition(pd_on, 0, `T_RISE_FALL_DEFAULT * 1p) / `TX_DRIVER_R_SEGMENT
            + transition(pd_eq_on, 0, `T_RISE_FALL_DEFAULT * 1p) / `TX_DRIVER_EQ_R_SEGMENT
        );

        // Leakage through the segments that are off or not selected.
        I(vddq, dout) <+ V(vddq, dout) / `DRIVER_R_OFF_SEGMENT;
        I(dout, vss) <+ V(dout, vss) / `DRIVER_R_OFF_SEGMENT;
    end
endmodule

module pad_driver_data_tb;
    localparam CYCLES = 16;    // number of test cycles
    reg din;
    reg [`PAD_DRIVER_CTL_BITS-1:0] pu_ctl, pd_ctlb;
    reg en, enb;
    electrical dout;
    electrical vdd, vss;
    real dout_sample;

    pad_driver_cell drv (
        .din(din),
        .pu_ctl(pu_ctl),
        .pd_ctlb(pd_ctlb),
        .en(en),
        .enb(enb),
        .dout(dout),
        .vdd(vdd),
        .vss(vss)
    );

    analog begin
        V(vdd) <+ `VDD;
        V(vss) <+ 0;
        dout_sample = V(dout);
    end

    initial begin
        pu_ctl = 0;
        pd_ctlb = {`PAD_DRIVER_CTL_BITS{1'b1}};
        en = 1;
        enb = 0;
    end

    integer i;
    reg actual;
    initial begin
        din = 0;
        #300;

        // Apply random inputs and check functionality
        for (i = 0; i < CYCLES; i=i+1) begin
            din = $random % 2;
            #300;
            actual = dout_sample > `VDD/2;
            $display("din = %b, dout = %b (analog %f V)", din, actual, dout_sample);
            if (actual !== din)
                $display("Error: dout does not match din");
        end

        $finish;
    end
endmodule

module pad_driver_impedance_tb;
    // TODO: Verify step size
    reg din;
    reg [`PAD_DRIVER_CTL_BITS-1:0] pu_ctl, pd_ctlb;
    reg en, enb;
    electrical dout;
    electrical vdd, vss;
    real dout_sample;

    pad_driver_cell drv (
        .din(din),
        .pu_ctl(pu_ctl),
        .pd_ctlb(pd_ctlb),
        .en(en),
        .enb(enb),
        .dout(dout),
        .vdd(vdd),
        .vss(vss)
    );

    analog begin
        V(vdd) <+ `VDD;
        V(vss) <+ 0;
        I(dout, vss) <+ V(dout, vss) / 50;
        I(vdd, dout) <+ V(vdd, dout) / 50;
        dout_sample = V(dout);
    end

    initial begin
        pu_ctl = 0;
        pd_ctlb = {`PAD_DRIVER_CTL_BITS{1'b1}};
        en = 1;
        enb = 0;
    end

    integer i;
    reg actual;
    real rtest;
    real r30;
    real vpu;
    real vpd;
    initial begin
        rtest = 50;
        r30 = 1/(1/`PAD_DRIVER_R_OUT + 1/rtest);
        vpu = rtest / (r30 + rtest) * `VDD;
        vpd = r30 / (r30 + rtest) * `VDD;
        din = 0;
        #300;

        // Check that lowest code is above 30 ohms
        $display("din = %b, pd_ctlb = %b, dout = %f", din, pd_ctlb, dout_sample);
        if (dout_sample < vpd) $display("Error: highest pull-down impedance is too low (vpd = %f)", vpd);
        pd_ctlb = 0;
        #300;
        $display("din = %b, pd_ctlb = %b, dout = %f", din, pd_ctlb, dout_sample);
        if (dout_sample > vpd) $display("Error: lowest pull-down impedance is too high (vpd = %f)", vpd);
        din = 1;
        #300;
        $display("din = %b, pu_ctl = %b, dout = %f", din, pu_ctl, dout_sample);
        if (dout_sample > vpu) $display("Error: highest pull-up impedance is too low (vpu = %f)", vpu);
        pu_ctl = {`PAD_DRIVER_CTL_BITS{1'b1}};
        #300;
        $display("din = %b, pu_ctl = %b, dout = %f", din, pu_ctl, dout_sample);
        if (dout_sample < vpu) $display("Error: lowest pull-up impedance is too high (vpu = %f)", vpu);

        $finish;
    end
endmodule

module tx_tile_driver_data_tb;
    localparam CYCLES = 16;    // number of test cycles
    reg din;
    reg [`TX_DRIVER_SEGMENTS-1:0] ENP, ENN;
    reg [`TX_DRIVER_EQ_SEGMENTS-1:0] ENP_EQ, ENN_EQ;
    electrical dout;
    electrical vddq, vss;
    real dout_sample;

    tx_tile_driver drv (
        .din(din),
        .ENP(ENP),
        .ENN(ENN),
        .ENP_EQ(ENP_EQ),
        .ENN_EQ(ENN_EQ),
        .dout(dout),
        .vddq(vddq),
        .vss(vss)
    );

    analog begin
        V(vddq) <+ `VDD;
        V(vss) <+ 0;
        dout_sample = V(dout);
    end

    // Every main segment on, equalizer branch off.
    initial begin
        ENP = 0;
        ENN = {`TX_DRIVER_SEGMENTS{1'b1}};
        ENP_EQ = {`TX_DRIVER_EQ_SEGMENTS{1'b1}};
        ENN_EQ = 0;
    end

    integer i;
    reg actual;
    initial begin
        din = 0;
        #300;

        // Apply random inputs and check functionality
        for (i = 0; i < CYCLES; i=i+1) begin
            din = $random % 2;
            #300;
            actual = dout_sample > `VDD/2;
            $display("din = %b, dout = %b (analog %f V)", din, actual, dout_sample);
            if (actual !== din)
                $display("Error: dout does not match din");
        end

        $finish;
    end
endmodule

module tx_tile_driver_impedance_tb;
    reg din;
    reg [`TX_DRIVER_SEGMENTS-1:0] ENP, ENN;
    reg [`TX_DRIVER_EQ_SEGMENTS-1:0] ENP_EQ, ENN_EQ;
    electrical dout;
    electrical vddq, vss;
    real dout_sample;

    tx_tile_driver drv (
        .din(din),
        .ENP(ENP),
        .ENN(ENN),
        .ENP_EQ(ENP_EQ),
        .ENN_EQ(ENN_EQ),
        .dout(dout),
        .vddq(vddq),
        .vss(vss)
    );

    analog begin
        V(vddq) <+ `VDD;
        V(vss) <+ 0;
        I(dout, vss) <+ V(dout, vss) / 50;
        I(vddq, dout) <+ V(vddq, dout) / 50;
        dout_sample = V(dout);
    end

    // One segment per rail, equalizer branch off: the weakest code the driver
    // can be set to short of turning off entirely.
    initial begin
        ENP = {`TX_DRIVER_SEGMENTS{1'b1}} << 1;
        ENN = 1;
        ENP_EQ = {`TX_DRIVER_EQ_SEGMENTS{1'b1}};
        ENN_EQ = 0;
    end

    real rtest;
    real r30;
    real vpu;
    real vpd;
    initial begin
        rtest = 50;
        r30 = 1/(1/`TX_R_OUT + 1/rtest);
        vpu = rtest / (r30 + rtest) * `VDD;
        vpd = r30 / (r30 + rtest) * `VDD;
        din = 0;
        #300;

        // The weakest pull-down code should sit above 30 ohms, the strongest
        // below it; likewise for the pull-up.
        $display("din = %b, ENN = %b, dout = %f", din, ENN, dout_sample);
        if (dout_sample < vpd) $display("Error: highest pull-down impedance is too low (vpd = %f)", vpd);
        ENN = {`TX_DRIVER_SEGMENTS{1'b1}};
        #300;
        $display("din = %b, ENN = %b, dout = %f", din, ENN, dout_sample);
        if (dout_sample > vpd) $display("Error: lowest pull-down impedance is too high (vpd = %f)", vpd);
        din = 1;
        #300;
        $display("din = %b, ENP = %b, dout = %f", din, ENP, dout_sample);
        if (dout_sample > vpu) $display("Error: highest pull-up impedance is too low (vpu = %f)", vpu);
        ENP = 0;
        #300;
        $display("din = %b, ENP = %b, dout = %f", din, ENP, dout_sample);
        if (dout_sample < vpu) $display("Error: lowest pull-up impedance is too high (vpu = %f)", vpu);

        $finish;
    end
endmodule
