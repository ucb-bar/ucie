// ****************************************************************
// AMS simulation control file for xrun netlist based flow
// ****************************************************************
simulator lang=spectre

global 0

amsd {
    ie vsup=0.75 tr=5p tf=5p rout=0
}

tran tran stop=1u annotate=status
